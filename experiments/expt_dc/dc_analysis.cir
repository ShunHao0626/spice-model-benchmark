* SPICE Model Verification - DC Analysis Testbench
* Based on CHECKLIST.md DC Analysis requirements
* ===================================================

* Simulator settings for accuracy and convergence
.option temp=27 tnom=27
.option gmin=1e-15
.option reltol=1e-8
.option abstol=1e-12
.option chgtol=1e-15
.option method=gear

* Include Synopsys28 model (REAL pdk_synopsys28 BSIM-SOI level=54)
.include "./synopsys28_real.spice"

* ===================================================
* 1. DC Operating Point Analysis
* ===================================================

* DC sweep - IV characteristics test circuit
Vds_iv drain_iv 0 DC 0
Vgs_iv gate_iv 0 DC 0
Vs_iv source_iv 0 DC 0
Vb_iv bulk_iv 0 DC 0

* MOSFET device under test - Synopsys28 transistor (28nm process)
* Using n105 model from Synopsys28
X1 drain_iv gate_iv source_iv bulk_iv n105 l=0.028u w=0.14u

* Bias point analysis circuit
Vds_bias drain_bias 0 DC 0
Vgs_bias gate_bias 0 DC 0
Vs_bias source_bias 0 DC 0
Vb_bias bulk_bias 0 DC 0

* MOSFET device for bias point analysis
X3 drain_bias gate_bias source_bias bulk_bias n105 l=0.028u w=0.14u

* ===================================================
* 2. Temperature Dependence
* ===================================================

* Temperature sweep test circuit (same as DC sweep circuit)
* Will use M1 for temperature sweep analysis

* ===================================================
* 3. Thermodynamic Analysis
* ===================================================

* Power and energy conservation test circuit
Vdd_therm vdd_therm 0 DC 1.2
Vgs_therm gate_therm 0 PULSE(0 1.2 1n 0.1n 0.1n 5n 10n)

* MOSFET for thermodynamic analysis
X_therm drain_therm gate_therm 0 0 n105 l=0.028u w=0.14u
Rload drain_therm vdd_therm 1k

* ===================================================
* 4. Physical Properties (Monotonicity, Symmetries)
* ===================================================

* Physical properties test circuit (geometry sweep)
Vds_phys drain_phys 0 DC 0.5
Vgs_phys gate_phys 0 DC 0
Vs_phys source_phys 0 DC 0
Vb_phys bulk_phys 0 DC 0

* MOSFET device for physical properties analysis
X1_phys drain_phys gate_phys source_phys bulk_phys n105 l=0.028u w=0.14u

* Control block
.control
set filetype=ascii
set wr_vecnames
set wr_singlescale
set wr_singleprecision
set wr_formatted

* Create synopsys28_output directory
shell mkdir -p ./synopsys28_output

* ===================================================
* 1. DC Operating Point Analysis
* ===================================================
echo "1. Starting DC Operating Point Analysis"

* Linear scale DC sweep (0V to 1.2V)
echo "Running linear scale I-V sweep"
dc Vds_iv 0 1.2 0.01 Vgs_iv 0 1.2 0.1
let id = i(Vds_iv)
let is = i(Vs_iv)
let ig = i(Vgs_iv)
let ib = i(Vb_iv)
let kcl = abs(id + is + ig + ib)
wrdata ./synopsys28_output/iv_linear.txt v(drain_iv) v(gate_iv) id is ib ig kcl

* Log scale DC sweep for sub-threshold analysis
echo "Running log scale I-V sweep"
dc Vgs_iv 0 1.2 0.01 Vds_iv 0.05 1.2 0.3
let id_log = log10(abs(i(Vds_iv)))
wrdata ./synopsys28_output/iv_log.txt v(gate_iv) v(drain_iv) id_log

* Multi-terminal DC analysis - KCL verification
echo "Running KCL verification"
dc Vds_iv 0 1.2 0.1 Vgs_iv 0 1.2 0.1
let id = i(Vds_iv)
let is = i(Vs_iv)
let ig = i(Vgs_iv)
let ib = i(Vb_iv)
let kcl_error = abs(id + is + ig + ib)
wrdata ./synopsys28_output/kcl_check.txt v(drain_iv) v(gate_iv) id is ib ig kcl_error

* Bias point analysis
echo "Running bias point analysis"

* Define bias points for analysis (need separate variables for each value)
let vds_0 = 0.0
let vds_1 = 0.2
let vds_2 = 0.4
let vds_3 = 0.6
let vds_4 = 0.8
let vds_5 = 1.0
let vds_6 = 1.2

let vgs_0 = 0.0
let vgs_1 = 0.2
let vgs_2 = 0.4
let vgs_3 = 0.6
let vgs_4 = 0.8
let vgs_5 = 1.0
let vgs_6 = 1.2

* Initialize synopsys28_output file
echo "Vds Vgs Id Gm Gds ro" > ./synopsys28_output/bias_point.txt

* Loop through bias points manually (ngspice doesn't support arrays well)
* Use DC sweep to get multiple bias points
dc Vds_bias 0 1.2 0.3 Vgs_bias 0 1.2 0.4
let id_bias = i(Vds_bias)
let gm = @x3.mmain[gm]
let gds = @x3.mmain[gds]
let ro = 1/(gds + 1e-15)
wrdata ./synopsys28_output/bias_point.txt v(drain_bias) v(gate_bias) id_bias gm gds ro

* ===================================================
* 2. Temperature Dependence
* ===================================================
echo "2. Starting Temperature Dependence Analysis"

* Temperature sweep simulations
* For each temperature point
option temp=-40
echo "Running simulation at temperature: -40 °C"
dc Vds_iv 0 1.2 0.05 Vgs_iv 0.6 1.2 0.1
let id = i(Vds_iv)
let is = i(Vs_iv)
let ig = i(Vgs_iv)
let ib = i(Vb_iv)
let kcl = abs(id + is + ig + ib)
wrdata ./synopsys28_output/iv_temp_n40.txt v(drain_iv) v(gate_iv) id is ib ig kcl

option temp=0
echo "Running simulation at temperature: 0 °C"
dc Vds_iv 0 1.2 0.05 Vgs_iv 0.6 1.2 0.1
let id = i(Vds_iv)
let is = i(Vs_iv)
let ig = i(Vgs_iv)
let ib = i(Vb_iv)
let kcl = abs(id + is + ig + ib)
wrdata ./synopsys28_output/iv_temp_0.txt v(drain_iv) v(gate_iv) id is ib ig kcl

option temp=25
echo "Running simulation at temperature: 25 °C"
dc Vds_iv 0 1.2 0.05 Vgs_iv 0.6 1.2 0.1
let id = i(Vds_iv)
let is = i(Vs_iv)
let ig = i(Vgs_iv)
let ib = i(Vb_iv)
let kcl = abs(id + is + ig + ib)
wrdata ./synopsys28_output/iv_temp_25.txt v(drain_iv) v(gate_iv) id is ib ig kcl

option temp=50
echo "Running simulation at temperature: 50 °C"
dc Vds_iv 0 1.2 0.05 Vgs_iv 0.6 1.2 0.1
let id = i(Vds_iv)
let is = i(Vs_iv)
let ig = i(Vgs_iv)
let ib = i(Vb_iv)
let kcl = abs(id + is + ig + ib)
wrdata ./synopsys28_output/iv_temp_50.txt v(drain_iv) v(gate_iv) id is ib ig kcl

option temp=100
echo "Running simulation at temperature: 100 °C"
dc Vds_iv 0 1.2 0.05 Vgs_iv 0.6 1.2 0.1
let id = i(Vds_iv)
let is = i(Vs_iv)
let ig = i(Vgs_iv)
let ib = i(Vb_iv)
let kcl = abs(id + is + ig + ib)
wrdata ./synopsys28_output/iv_temp_100.txt v(drain_iv) v(gate_iv) id is ib ig kcl

option temp=150
echo "Running simulation at temperature: 150 °C"
dc Vds_iv 0 1.2 0.05 Vgs_iv 0.6 1.2 0.1
let id = i(Vds_iv)
let is = i(Vs_iv)
let ig = i(Vgs_iv)
let ib = i(Vb_iv)
let kcl = abs(id + is + ig + ib)
wrdata ./synopsys28_output/iv_temp_150.txt v(drain_iv) v(gate_iv) id is ib ig kcl

* Temperature coefficient calculation
* Create a file to hold the temperature data
echo "# Current measurements at different temperatures for coefficient calculation" > ./synopsys28_output/temp_current_data.txt
echo "Temperature Gate Drain Current" >> ./synopsys28_output/temp_current_data.txt

* Reference temperature point (25°C)
option temp=25
* Use fixed bias conditions for consistency
dc Vgs_iv 0.8 0.8 0.01 Vds_iv 1.0 1.0 0.01
* Get current measurement at 25°C
let id_25c = i(Vds_iv)
* Store in file
echo "25 0.8 1.0 $&id_25c" >> ./synopsys28_output/temp_current_data.txt

* High temperature point (125°C)
option temp=125
* Use same bias conditions
dc Vgs_iv 0.8 0.8 0.01 Vds_iv 1.0 1.0 0.01
* Get current measurement at 125°C
let id_125c = i(Vds_iv)
* Store in file
echo "125 0.8 1.0 $&id_125c" >> ./synopsys28_output/temp_current_data.txt

* Calculate temperature coefficient directly
let delta_id = id_125c - id_25c
let delta_temp = 100.0
let tc = delta_id / delta_temp
* Store in regular synopsys28_output files for backward compatibility
echo "Temperature coefficient: $&tc A/°C" > ./synopsys28_output/temp_coeff.txt
echo "$&tc" > ./synopsys28_output/temp_coeff_value.txt

* ===================================================
* 3. Thermodynamic Analysis
* ===================================================
echo "3. Starting Thermodynamic Analysis"

* Energy conservation verification
option temp=27
dc Vdd_therm 0 1.2 0.1 Vgs_therm 0 1.2 0.1
let id_therm = i(vdd_therm)
let power = v(vdd_therm) * id_therm
let efficiency = abs(v(drain_therm) * i(vdd_therm)) / (v(vdd_therm) * i(vdd_therm) + 1e-15)
wrdata ./synopsys28_output/power_analysis.txt v(vdd_therm) v(gate_therm) id_therm power efficiency

* Power temperature coefficient - Use a simpler direct approach
* First, clear the synopsys28_output files
echo "# Power calculation at 25C and 125C for temperature coefficient" > ./synopsys28_output/power_temp_data.txt
echo "Temperature Current Voltage Power" >> ./synopsys28_output/power_temp_data.txt

* Run operating point analysis at 25°C with fixed bias
option temp=25
* Set a known bias condition
alter Vdd_therm = 1.2
alter Vgs_therm = 1.2
* Use a simple DC sweep instead of op to ensure vector availability
dc Vgs_therm 1.2 1.2 0.1
* Calculate values directly
let i_25c = i(vdd_therm)
let v_25c = v(drain_therm)
let p_25c = abs(i_25c * v_25c)
* Output directly to file
echo "25 $&i_25c $&v_25c $&p_25c" >> ./synopsys28_output/power_temp_data.txt

* Repeat for 125°C temperature
option temp=125
* Use same bias point
dc Vgs_therm 1.2 1.2 0.1
* Calculate values directly
let i_125c = i(vdd_therm)
let v_125c = v(drain_therm)
let p_125c = abs(i_125c * v_125c)
* Output directly to file
echo "125 $&i_125c $&v_125c $&p_125c" >> ./synopsys28_output/power_temp_data.txt

* Calculate power temperature coefficient
let power_diff = p_125c - p_25c
let temp_diff = 100.0
let power_ratio = power_diff / (abs(p_25c) + 1e-12)
let p_tc = power_ratio / temp_diff
echo "# Power temperature coefficient" > ./synopsys28_output/power_temp_coeff.txt
echo "# Power at 25°C: $&p_25c W" >> ./synopsys28_output/power_temp_coeff.txt
echo "# Power at 125°C: $&p_125c W" >> ./synopsys28_output/power_temp_coeff.txt
echo "# Coefficient: $&p_tc /°C" >> ./synopsys28_output/power_temp_coeff.txt
echo "$&p_tc" > ./synopsys28_output/power_temp_coeff_value.txt

* ===================================================
* 4. Physical Properties
* ===================================================
echo "4. Checking Physical Properties"

* Monotonicity check - need Vds > 0 to get current
alter Vds_phys = 0.5
dc Vgs_phys 0 1.2 0.01
let id_mono = i(Vds_phys)
let diff_id = deriv(id_mono)
wrdata ./synopsys28_output/monotonicity.txt v(gate_phys) id_mono diff_id

* Check for physical symmetries
echo "Testing physical symmetries"

* Parameter sweep - vary geometry manually rather than with arrays
echo "W L Id Gm Gds" > ./synopsys28_output/param_sweep.txt

* Fix bias point
alter Vds_phys = 1.0
alter Vgs_phys = 0.8

* W=0.07, L=0.028 (28nm process)
alter @x1_phys[l] = 0.028u
alter @x1_phys[w] = 0.07u
op
let id_geom = op.i(vds_phys)
let gm_geom = @x1_phys.mmain[gm]
let gds_geom = @x1_phys.mmain[gds]
echo "1.0 0.018 $&id_geom $&gm_geom $&gds_geom" >> ./synopsys28_output/param_sweep.txt

* W=0.35, L=0.028 (28nm process)
alter @x1_phys[l] = 0.028u
alter @x1_phys[w] = 0.35u
op
let id_geom = op.i(vds_phys)
let gm_geom = @x1_phys.mmain[gm]
let gds_geom = @x1_phys.mmain[gds]
echo "5.0 0.018 $&id_geom $&gm_geom $&gds_geom" >> ./synopsys28_output/param_sweep.txt

* W=0.7, L=0.028 (28nm process)
alter @x1_phys[l] = 0.028u
alter @x1_phys[w] = 0.7u
op
let id_geom = op.i(vds_phys)
let gm_geom = @x1_phys.mmain[gm]
let gds_geom = @x1_phys.mmain[gds]
echo "10.0 0.018 $&id_geom $&gm_geom $&gds_geom" >> ./synopsys28_output/param_sweep.txt

* W=0.7, L=0.056 (28nm process)
alter @x1_phys[l] = 0.056u
alter @x1_phys[w] = 0.7u
op
let id_geom = op.i(vds_phys)
let gm_geom = @x1_phys.mmain[gm]
let gds_geom = @x1_phys.mmain[gds]
echo "10.0 0.036 $&id_geom $&gm_geom $&gds_geom" >> ./synopsys28_output/param_sweep.txt

* W=0.7, L=0.112 (28nm process)
alter @x1_phys[l] = 0.112u
alter @x1_phys[w] = 0.7u
op
let id_geom = op.i(vds_phys)
let gm_geom = @x1_phys.mmain[gm]
let gds_geom = @x1_phys.mmain[gds]
echo "10.0 0.072 $&id_geom $&gm_geom $&gds_geom" >> ./synopsys28_output/param_sweep.txt

* Terminal permutation tests
echo "Terminal permutation tests"

* Create the synopsys28_output file with header
echo "# Terminal symmetry test data" > ./synopsys28_output/terminal_symmetry.txt
echo "# Tests if swapping drain and source leads to the same behavior" >> ./synopsys28_output/terminal_symmetry.txt
echo "# Vgs id_normal id_reversed id_diff" >> ./synopsys28_output/terminal_symmetry.txt

* Fix width and length for consistent measurements
alter @x1_phys[l] = 0.028u
alter @x1_phys[w] = 0.7u

* Loop through gate voltages and measure terminal symmetry
* Collect all data points, then write once
* Gate voltage = 0.2V
alter Vgs_phys = 0.2
alter Vds_phys = 0.1
op
let id_normal_02 = i(Vds_phys)
alter Vds_phys = -0.1
op
let id_reversed_02 = -i(Vds_phys)
let id_diff_02 = id_normal_02 - id_reversed_02

* Gate voltage = 0.4V
alter Vgs_phys = 0.4
alter Vds_phys = 0.1
op
let id_normal_04 = i(Vds_phys)
alter Vds_phys = -0.1
op
let id_reversed_04 = -i(Vds_phys)
let id_diff_04 = id_normal_04 - id_reversed_04

* Gate voltage = 0.6V
alter Vgs_phys = 0.6
alter Vds_phys = 0.1
op
let id_normal_06 = i(Vds_phys)
alter Vds_phys = -0.1
op
let id_reversed_06 = -i(Vds_phys)
let id_diff_06 = id_normal_06 - id_reversed_06

* Gate voltage = 0.8V
alter Vgs_phys = 0.8
alter Vds_phys = 0.1
op
let id_normal_08 = i(Vds_phys)
alter Vds_phys = -0.1
op
let id_reversed_08 = -i(Vds_phys)
let id_diff_08 = id_normal_08 - id_reversed_08

* Gate voltage = 1.0V
alter Vgs_phys = 1.0
alter Vds_phys = 0.1
op
let id_normal_10 = i(Vds_phys)
alter Vds_phys = -0.1
op
let id_reversed_10 = -i(Vds_phys)
let id_diff_10 = id_normal_10 - id_reversed_10

* Gate voltage = 1.2V
alter Vgs_phys = 1.2
alter Vds_phys = 0.1
op
let id_normal_12 = i(Vds_phys)
alter Vds_phys = -0.1
op
let id_reversed_12 = -i(Vds_phys)
let id_diff_12 = id_normal_12 - id_reversed_12

* Now create vectors with all data points and write once
let vgs_sym_vec[0] = 0.2
let vgs_sym_vec[1] = 0.4
let vgs_sym_vec[2] = 0.6
let vgs_sym_vec[3] = 0.8
let vgs_sym_vec[4] = 1.0
let vgs_sym_vec[5] = 1.2

let id_norm_sym_vec[0] = id_normal_02
let id_norm_sym_vec[1] = id_normal_04
let id_norm_sym_vec[2] = id_normal_06
let id_norm_sym_vec[3] = id_normal_08
let id_norm_sym_vec[4] = id_normal_10
let id_norm_sym_vec[5] = id_normal_12

let id_rev_sym_vec[0] = id_reversed_02
let id_rev_sym_vec[1] = id_reversed_04
let id_rev_sym_vec[2] = id_reversed_06
let id_rev_sym_vec[3] = id_reversed_08
let id_rev_sym_vec[4] = id_reversed_10
let id_rev_sym_vec[5] = id_reversed_12

let id_diff_sym_vec[0] = id_diff_02
let id_diff_sym_vec[1] = id_diff_04
let id_diff_sym_vec[2] = id_diff_06
let id_diff_sym_vec[3] = id_diff_08
let id_diff_sym_vec[4] = id_diff_10
let id_diff_sym_vec[5] = id_diff_12

* Write all data at once
wrdata ./synopsys28_output/terminal_symmetry.txt vgs_sym_vec id_norm_sym_vec id_rev_sym_vec id_diff_sym_vec

* Cross-derivative analysis - Fix implementation
* Testing the symmetry of cross-derivatives (e.g., dgm/dVds = dgds/dVgs)

* Ensure we use a stronger bias point to get meaningful transconductance
alter @x1_phys[l] = 0.028u
alter @x1_phys[w] = 0.7u
alter Vds_phys = 0.5
alter Vgs_phys = 0.8
op
let gm1 = @x1_phys.mmain[gm]
let gds1 = @x1_phys.mmain[gds]
print gm1
print gds1

* Calculate dgm/dVds - Take a larger step for numerical stability
alter Vds_phys = 0.7
op
let gm2 = @x1_phys.mmain[gm]
let dgm_dvds = (gm2 - gm1) / 0.2
print dgm_dvds

* Calculate dgds/dVgs
alter Vds_phys = 0.5
alter Vgs_phys = 1.0
op
let gds2 = @x1_phys.mmain[gds]
let dgds_dvgs = (gds2 - gds1) / 0.2
print dgds_dvgs

* Calculate difference
let cross_diff = abs(dgm_dvds - dgds_dvgs)
print cross_diff

* Create vectors with single values for wrdata
let vgs_vec[0] = 0.8
let vds_vec[0] = 0.5
let dgm_vec[0] = dgm_dvds
let dgds_vec[0] = dgds_dvgs
let cross_vec[0] = cross_diff
wrdata ./synopsys28_output/cross_derivative.txt vgs_vec vds_vec dgm_vec dgds_vec cross_vec

* Additional physical symmetry tests - Current symmetry with better implementation
* Set up bias conditions - Use larger values for more reliable results
alter @x1_phys[l] = 0.028u
alter @x1_phys[w] = 0.7u

* Collect all data points into vectors, then write once
* VGS = 0.0V
alter Vds_phys = 0.5
alter Vgs_phys = 0.0
op
let id_pos_0 = i(Vds_phys)
alter Vds_phys = -0.5
op
let id_neg_0 = -i(Vds_phys)
let sym_err_0 = abs((id_pos_0 - id_neg_0)/(max(abs(id_pos_0), abs(id_neg_0)) + 1e-12)*100)

* VGS = 0.2V
alter Vds_phys = 0.5
alter Vgs_phys = 0.2
op
let id_pos_2 = i(Vds_phys)
alter Vds_phys = -0.5
op
let id_neg_2 = -i(Vds_phys)
let sym_err_2 = abs((id_pos_2 - id_neg_2)/(max(abs(id_pos_2), abs(id_neg_2)) + 1e-12)*100)

* VGS = 0.4V
alter Vds_phys = 0.5
alter Vgs_phys = 0.4
op
let id_pos_4 = i(Vds_phys)
alter Vds_phys = -0.5
op
let id_neg_4 = -i(Vds_phys)
let sym_err_4 = abs((id_pos_4 - id_neg_4)/(max(abs(id_pos_4), abs(id_neg_4)) + 1e-12)*100)

* VGS = 0.6V
alter Vds_phys = 0.5
alter Vgs_phys = 0.6
op
let id_pos_6 = i(Vds_phys)
alter Vds_phys = -0.5
op
let id_neg_6 = -i(Vds_phys)
let sym_err_6 = abs((id_pos_6 - id_neg_6)/(max(abs(id_pos_6), abs(id_neg_6)) + 1e-12)*100)

* VGS = 0.8V
alter Vds_phys = 0.5
alter Vgs_phys = 0.8
op
let id_pos_8 = i(Vds_phys)
alter Vds_phys = -0.5
op
let id_neg_8 = -i(Vds_phys)
let sym_err_8 = abs((id_pos_8 - id_neg_8)/(max(abs(id_pos_8), abs(id_neg_8)) + 1e-12)*100)

* VGS = 1.0V
alter Vds_phys = 0.5
alter Vgs_phys = 1.0
op
let id_pos_10 = i(Vds_phys)
alter Vds_phys = -0.5
op
let id_neg_10 = -i(Vds_phys)
let sym_err_10 = abs((id_pos_10 - id_neg_10)/(max(abs(id_pos_10), abs(id_neg_10)) + 1e-12)*100)

* VGS = 1.2V
alter Vds_phys = 0.5
alter Vgs_phys = 1.2
op
let id_pos_12 = i(Vds_phys)
alter Vds_phys = -0.5
op
let id_neg_12 = -i(Vds_phys)
let sym_err_12 = abs((id_pos_12 - id_neg_12)/(max(abs(id_pos_12), abs(id_neg_12)) + 1e-12)*100)

* Now create vectors with all data points
let vgs_sym_vec[0] = 0.0
let vgs_sym_vec[1] = 0.2
let vgs_sym_vec[2] = 0.4
let vgs_sym_vec[3] = 0.6
let vgs_sym_vec[4] = 0.8
let vgs_sym_vec[5] = 1.0
let vgs_sym_vec[6] = 1.2

let id_pos_sym_vec[0] = id_pos_0
let id_pos_sym_vec[1] = id_pos_2
let id_pos_sym_vec[2] = id_pos_4
let id_pos_sym_vec[3] = id_pos_6
let id_pos_sym_vec[4] = id_pos_8
let id_pos_sym_vec[5] = id_pos_10
let id_pos_sym_vec[6] = id_pos_12

let id_neg_sym_vec[0] = id_neg_0
let id_neg_sym_vec[1] = id_neg_2
let id_neg_sym_vec[2] = id_neg_4
let id_neg_sym_vec[3] = id_neg_6
let id_neg_sym_vec[4] = id_neg_8
let id_neg_sym_vec[5] = id_neg_10
let id_neg_sym_vec[6] = id_neg_12

let sym_err_sym_vec[0] = sym_err_0
let sym_err_sym_vec[1] = sym_err_2
let sym_err_sym_vec[2] = sym_err_4
let sym_err_sym_vec[3] = sym_err_6
let sym_err_sym_vec[4] = sym_err_8
let sym_err_sym_vec[5] = sym_err_10
let sym_err_sym_vec[6] = sym_err_12

* Write all data at once
wrdata ./synopsys28_output/current_symmetry_sweep.txt vgs_sym_vec id_pos_sym_vec id_neg_sym_vec sym_err_sym_vec

* Make sure we also create a proper current_symmetry.txt file (use VGS=0.8V data)
let vgs_curr_vec[0] = 0.8
let id_norm_vec[0] = id_pos_8
let id_pos_curr_vec[0] = id_pos_8
let id_neg_curr_vec[0] = id_neg_8
let sym_err_curr_vec[0] = sym_err_8
wrdata ./synopsys28_output/current_symmetry.txt vgs_curr_vec id_norm_vec id_pos_curr_vec id_neg_curr_vec sym_err_curr_vec

* Complete simulation
echo "DC analysis testbench completed successfully"
quit
.endc

.end
